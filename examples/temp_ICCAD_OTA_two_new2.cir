* Two-Stage Miller OTA - GF180MCU - Parametric
.PARAM cap=5.5pf l1=0.74u l2=0.47u l3=0.44u l4=2.06u l5=4.04u r=175.81145416433864 w1=47.33u w2=84.65u w3=29.87u w4=70.99u w5=94.52u w_tail=99.02u nf1=1 nf2=2 nf3=1 nf4=2 nf5=11 nf_tail=21

.include '/home/admin/gf180mcu-pdk/libraries/gf180mcu_fd_pr/latest/models/ngspice/design.ngspice'
.lib '/home/admin/gf180mcu-pdk/libraries/gf180mcu_fd_pr/latest/models/ngspice/sm141064.ngspice' typical
.param sw_stat_mismatch = 0

V0 vdd 0 DC 3.3

* BIAS: 20uA ref
Ibias vdd vbn DC 20u
XMbn vbn vbn 0 0 nmos_3p3 w=w5 nf=nf5 l=l5

* STAGE 1
XM5 net_tail vbn 0 0 nmos_3p3 w=w_tail nf=nf_tail l=l5
XM1a net1 net3 net_tail 0 nmos_3p3 w=w1 nf=nf1 l=l1
XM1b net2 inn net_tail 0 nmos_3p3 w=w1 nf=nf1 l=l1
XM2a net1 net1 vdd vdd pmos_3p3 w=w2 nf=nf2 l=l2
XM2b net2 net1 vdd vdd pmos_3p3 w=w2 nf=nf2 l=l2

* STAGE 2
XM3 net4 net2 vdd vdd pmos_3p3 w=w3 nf=nf3 l=l3
XM4 net4 vbn 0 0 nmos_3p3 w=w4 nf=nf4 l=l4

* Compensation
Cc net4 net_cc {cap}
Rc net_cc net2 {r}

Vcm inn 0 DC 1.65
Vinp net3 0 DC 1.65 AC 1

.op
.ac dec 100 1 1G

.control
run
echo "=== DC ==="
print v(vbn) v(net_tail) v(net1) v(net2) v(net4)

let gain_db = vdb(net4)
meas ac dc_gain max gain_db
meas ac ugf when gain_db=0 cross=1
meas ac pm find vp(net4) when gain_db=0 cross=1
echo "=== AC ==="
print dc_gain ugf pm
.endc
.end
