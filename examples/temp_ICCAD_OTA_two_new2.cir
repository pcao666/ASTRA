.PARAM cap=2.0pf l1=1.00u l2=1.00u l3=1.00u l4=1.00u l5=1.00u r=3000.0 w1=28.63u w2=120.70u w3=37.71u w4=28.49u w5=57.26u
* Two-Stage Miller OTA - GF180MCU - W<100u, L>=0.28u
.include '/home/admin/gf180mcu-pdk/libraries/gf180mcu_fd_pr/latest/models/ngspice/design.ngspice'
.lib '/home/admin/gf180mcu-pdk/libraries/gf180mcu_fd_pr/latest/models/ngspice/sm141064.ngspice' typical
.param sw_stat_mismatch = 0

V0 vdd 0 DC 3.3

* BIAS: 20uA ref
Ibias vdd vbn DC 20u
XMbn vbn vbn 0 0 nmos_3p3 w=5u l=2u

* STAGE 1
XM5 net_tail vbn 0 0 nmos_3p3 w=10u l=2u
XM1a net1 net3 net_tail 0 nmos_3p3 w=20u l=1u
XM1b net2 inn net_tail 0 nmos_3p3 w=20u l=1u
XM2a net1 net1 vdd vdd pmos_3p3 w=40u l=1u
XM2b net2 net1 vdd vdd pmos_3p3 w=40u l=1u

* STAGE 2
XM3 net4 net2 vdd vdd pmos_3p3 w=80u l=0.6u
XM4 net4 vbn 0 0 nmos_3p3 w=25u l=2u

* Compensation
Cc net4 net_cc 2p
Rc net_cc net2 3000

Vcm inn 0 DC 1.65
Vinp net3 0 DC 1.65 AC 1

.op
.ac dec 100 1 1G

.control
run
echo "=== DC ==="
print v(vbn) v(net_tail) v(net1) v(net2) v(net4)

let gain_db = vdb(net4)
meas ac dc_gain max gain_db
meas ac ugf when gain_db=0 cross=1
meas ac pm find vp(net4) when gain_db=0 cross=1
echo "=== AC ==="
print dc_gain ugf pm
.endc
.end
